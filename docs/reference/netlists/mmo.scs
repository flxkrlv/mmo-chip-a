// Spectre hierarchical netlist generated by mmo-chip
// Source: lm2937_stud
// Date: 2026-07-09

subckt lm2937_stud (Net_10 Net_101 Net_102 Net_105 Net_107 Net_108 Net_109 Net_11 Net_112 Net_113 Net_114 Net_115 Net_116 Net_117 Net_118 Net_119 Net_12 Net_121 Net_122 Net_123 Net_124 Net_125 Net_127 Net_129 Net_130 Net_131 Net_131__2_ Net_133 Net_134 Net_135 Net_136 Net_137 Net_138 Net_138__2_ Net_139 Net_14 Net_140 Net_19 Net_20 Net_21 Net_22 Net_27 Net_28 Net_29 Net_3 Net_30 Net_33 Net_35 Net_37 Net_39 Net_4 Net_40 Net_43 Net_44 Net_45 Net_49 Net_5 Net_50 Net_51 Net_52 Net_53 Net_54 Net_56 Net_57 Net_59__2_ Net_6 Net_61 Net_65 Net_66__2_ Net_67 Net_68 Net_69 Net_7 Net_70 Net_71__2_ Net_72 Net_73 Net_74 Net_75 Net_76 Net_79 Net_81 Net_85 Net_87 Net_88 Net_89 Net_9 Net_90 Net_91 Net_93 Net_94 Net_95 Net_96__2_ Net_97 Net_98 Net_99 net2451 net2582 net2831 net2841 net2881 net2890 net2891 net2901 net2910 net2911 net2921 net2930 net2931 net2941 net2951 net2961 net2971 net2980 net2981 net2990 net3000 net3010 net3011 net3020 net3021 net3030 net3071 net3081 net3091 net3161 net3170 net3230 VCC GND)
  parameters Rbase=150 Rnpl=10
  R1 (Net_5 Net_6) resistor r=19.9*Rbase
  R2 (Net_3 Net_125) resistor r=19.9*Rbase
  R3 (Net_7 Net_6) resistor r=19.9*Rbase
  R4 (Net_124 Net_125) resistor r=19.9*Rbase
  R5 (Net_7 Net_9) resistor r=19.9*Rbase
  R6 (Net_124 Net_9) resistor r=19.9*Rbase
  Q1 (Net_59__2_ Net_39 GND) npn m=3.6
  Q2 (Net_54 Net_19 GND) npn m=2.87
  Q3 (Net_28 Net_19 GND) npn m=2.87
  Q4 (Net_28 Net_4 Net_3) pnp m=1.97
  Q5 (GND Net_4 Net_3) pnp m=1.93
  Q6 (GND Net_73 Net_5) pnp m=1.93
  Q7 (Net_54 Net_129 Net_5) pnp m=2.03
  Q8 (Net_40 Net_12 Net_10) pnp m=1.1
  Q9 (Net_9 Net_12 Net_10) pnp
  Q10 (Net_11 Net_11 Net_10) pnp m=1.36
  Q11 (Net_14 Net_40 Net_91) npn m=3.28
  R7 (Net_93 Net_14) resistor r=1.3*Rnpl
  Q12 (Net_37 Net_35 Net_22) npn m=2.7
  Q13 (Net_35 Net_35 GND) npn m=3.47
  Q14 (Net_76 Net_37 GND) npn m=3.47
  Q15 (Net_40 Net_28 GND) npn m=3.47
  Q16 (Net_122 Net_116 GND) npn m=3.47
  C1 (Net_28 Net_27) capacitor c=34570.868f
  R8 (Net_22 Net_29) resistor r=19.4*Rbase
  R9 (GND Net_33) resistor r=19.4*Rbase
  R10 (Net_21 Net_30) resistor r=19.4*Rbase
  R11 (GND Net_30) resistor r=19.4*Rbase
  R12 (Net_20 Net_33) resistor r=19.4*Rbase
  R13 (GND Net_29) resistor r=19.4*Rbase
  R14 (Net_39 GND) resistor r=4.6*Rbase
  R15 (Net_39 GND) resistor r=4.5*Rbase
  R16 (Net_76 Net_50) resistor r=16.9*Rbase
  R17 (Net_35 Net_50) resistor r=16.9*Rbase
  Q17 (Net_135 Net_76 Net_73) npn m=3.17
  Q18 (Net_57 Net_76 Net_49) npn m=3.17
  R18 (Net_136 Net_52) resistor r=15.8*Rbase
  R19 (Net_137 Net_52) resistor r=16*Rbase
  R20 (Net_76 Net_51) resistor r=16.1*Rbase
  R21 (Net_136 Net_51) resistor r=16.1*Rbase
  R22 (Net_137 Net_53) resistor r=23.3*Rbase
  R23 (Net_53 Net_138__2_) resistor r=11.7*Rbase
  R24 (Net_138__2_ Net_138) resistor r=6.4*Rbase
  R25 (Net_138 Net_138__2_) resistor r=3.9*Rbase
  R26 (Net_138__2_ Net_43) resistor r=4*Rbase
  R27 (Net_76 net2451) resistor r=13.1*Rbase
  R28 (net2451 Net_4) resistor r=10.1*Rbase
  R29 (Net_138__2_ Net_43) resistor r=4.1*Rbase
  R30 (Net_49 Net_56) resistor r=5.9*Rbase
  R31 (Net_45 Net_44) resistor r=12.4*Rbase
  R32 (Net_57 Net_59__2_) resistor r=5.8*Rbase
  Q19 (Net_123 Net_112 Net_117) pnp m=1.84
  Q20 (Net_28 Net_59__2_ Net_57) pnp m=1.83
  R34 (Net_116 Net_123) resistor r=6.1*Rbase
  R35 (Net_115 Net_123) resistor r=6.1*Rbase
  R36 (Net_123 Net_61) resistor r=6.2*Rbase
  R37 (Net_89 Net_127) resistor r=6.3*Rbase
  R38 (Net_112 Net_117) resistor r=7.2*Rbase
  Q21 (Net_109 Net_61 net2582) npn
  R39 (Net_112 GND) resistor r=19.1*Rbase
  R40 (Net_89 Net_90) resistor r=4.2*Rbase
  D1 (Net_66__2_ Net_65) diode
  Q22 (Net_87 Net_87 Net_72) npn m=24.17
  Q23 (Net_88 Net_87 Net_96__2_) npn m=2.38
  R41 (Net_27 Net_40) resistor r=14.1*Rbase
  R42 (Net_96__2_ Net_72) resistor r=6.6*Rbase
  R43 (Net_114 Net_113) resistor r=13.4*Rbase
  R44 (Net_108 Net_75) resistor r=5.4*Rbase
  R45 (Net_28 Net_139) resistor r=3.8*Rbase
  D2 (Net_94 Net_95) diode
  D3 (Net_75 Net_94) diode
  D4 (Net_95 Net_74) diode
  D5 (Net_107 Net_93) diode
  D6 (Net_79 Net_88) diode
  Q24 (Net_65 Net_88 Net_87) npn
  Q25 (Net_105 Net_67 VCC) pnp m=2.04
  D7 (Net_68 Net_67) diode
  D8 (Net_70 Net_68) diode
  D9 (Net_71__2_ Net_69) diode
  D10 (Net_69 Net_70) diode
  R46 (Net_96__2_ Net_81) resistor r=8*Rbase
  Q26 (Net_79 Net_81 Net_96__2_) npn m=1.43
  Q27 (Net_131__2_ Net_133 GND) npn m=3.72
  R49 (Net_99 net2831) resistor r=11.8*Rbase
  R50 (net2831 net2841) resistor r=4.5*Rbase
  R51 (Net_90 Net_91) resistor r=6.9*Rbase
  D11 (Net_115 GND) diode
  R52 (Net_99 Net_98) resistor r=14.6*Rbase
  R53 (Net_98 net2881) resistor r=14.4*Rbase
  R54 (net2890 net2891) resistor r=15.9*Rbase
  R55 (net2891 net2901) resistor r=15.2*Rbase
  R56 (net2910 net2911) resistor r=15.3*Rbase
  R57 (net2911 net2921) resistor r=15.2*Rbase
  R58 (net2930 net2931) resistor r=15.2*Rbase
  R59 (net2931 net2941) resistor r=15.3*Rbase
  R60 (Net_97 net2951) resistor r=15.3*Rbase
  R61 (net2951 net2961) resistor r=15.1*Rbase
  R62 (Net_76 net2971) resistor r=16.9*Rbase
  R63 (net2980 net2981) resistor r=16.5*Rbase
  R64 (net2990 Net_98) resistor r=15.5*Rbase
  R65 (net3000 GND) resistor r=18.5*Rbase
  R66 (net3010 net3011) resistor r=15.6*Rbase
  R67 (net3020 net3021) resistor r=15.6*Rbase
  R68 (net3030 Net_76) resistor r=15.2*Rbase
  R69 (net2971 GND) resistor r=15.6*Rbase
  R70 (net2981 GND) resistor r=16.0*Rbase
  R71 (Net_98 Net_85) resistor r=15.3*Rbase
  R72 (GND net3071) resistor r=15.9*Rbase
  R73 (net3011 net3081) resistor r=18.3*Rbase
  R74 (net3021 net3091) resistor r=15.5*Rbase
  R75 (Net_76 Net_85) resistor r=17.2*Rbase
  Q28 (Net_102 Net_121 VCC) pnp m=9.68
  Q29 (Net_65 Net_121 VCC) pnp m=3.7
  Q30 (Net_101 Net_121 VCC) pnp m=2.65
  Q31 (Net_81 Net_121 VCC) pnp m=3.52
  Q32 (Net_105 Net_121 VCC) pnp m=3.14
  R76 (Net_71__2_ net3161) resistor r=10.6*Rbase
  R77 (net3170 Net_118) resistor r=11.5*Rbase
  R78 (Net_118 Net_117) resistor r=16.3*Rbase
  R79 (net3161 net3170) resistor r=9.9*Rbase
  Q37 (Net_66__2_ Net_88 Net_101) pnp m=2
  Q38 (Net_140 Net_108 Net_102) pnp m=2
  Q34 (Net_119 Net_119 VCC) pnp m=1.31
  Q35 (net3230 Net_131 Net_127) npn m=37.68
  Q36 (Net_133 Net_130 Net_134) pnp
  R80 (Net_127 GND) resistor r=1.8*Rbase
  R81 (GND Net_127) resistor r=1.6*Rbase
ends lm2937_stud
