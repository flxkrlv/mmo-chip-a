* SPICE hierarchical netlist test for spice-ts subcircuit support
* Source: lmv341 (adapted)
.GLOBAL VDD GND

.PARAM Rp=25
.PARAM Rbase=200

.MODEL PMOS PMOS (VTO=-0.7 KP=40u LAMBDA=0.02)
.MODEL NMOS NMOS (VTO=0.7 KP=120u LAMBDA=0.01)
.MODEL NPN_GEN NPN (BF=200 IS=1e-14 VAF=100)
.MODEL D_GEN D (IS=1e-14 BV=50)

.SUBCKT smth in1 vref1 VDD GND
 M1 vref1 in1 Net_21 VDD PMOS W=48.538u L=4.883u
 M2 Net_60 net2181 net2182 Net_60 PMOS W=47.102u L=12.350u m=2
 M3 net2190 Net_59 Net_60 Net_60 PMOS W=47.102u L=12.350u m=2
.ENDS smth

.SUBCKT bjt VDD GND
 Q1 VDD_1 net2021 Net_61 NPN_GEN
.ENDS bjt

.SUBCKT fptest2 in1 inp maybeout2 VDD GND
 M1 net2050 inp net2052 GND NMOS W=60.314u L=12.063u
 M2 Net_41 Net_40 Net_37 GND NMOS W=60.314u L=12.063u
 M3 Net_44 Net_43 Net_42 GND NMOS W=60.314u L=12.063u
 M4 out1 Net_46 Net_45 GND NMOS W=60.314u L=12.063u
 M5 out1__2_ net2091 net2092 GND NMOS W=60.314u L=12.063u
 M6 out1__2_ net2101 net2102 GND NMOS W=60.314u L=12.063u
 M7 net2110 net2111 net2112 GND NMOS W=60.314u L=12.063u
 M8 net2130 maybeout2 net2132 GND NMOS W=60.026u L=1.723u
 M9 Net_38 Net_49 Net_39 GND NMOS W=60.026u L=1.723u
 M10 in1 Net_48 net2152 GND NMOS W=60.026u L=1.723u
.ENDS fptest2

.SUBCKT lmv341 Net_58 Net_63 Net_64 Net_65 Net_66 Net_67 Net_68 Net_69 Net_70 Net_71 Net_72 Net_73 Net_74 Net_75 Net_76 Net_77 Net_79 Net_80 in1 in2 inp maybeout2 net2041 net2042 net2043 net2122 net2161 net2162 net2171 net2173 net2200 net2201 net2202 net2203 net2210 net2211 net2222 net2230 net2232 net2241 net2242 net2250 net2251 net2252 net2260 net2261 net2272 net2280 net2282 net2292 net2301 net2302 net2311 net2312 net2320 net2322 net2330 net2331 net2332 net2340 net2341 net2342 net2350 net2351 net2352 net2361 net2362 net2370 net2371 net2381 net2390 net2410 net2411 net2420 net2421 net2430 net2431 vref1 VDD GND
 X1 in1 vref1 VDD GND smth
 X2 VDD GND bjt
 X3 in1 inp maybeout2 VDD GND fptest2
 Q1 Net_67 Net_58 Net_67 NPN_GEN
 D1 inp maybeout2 D_GEN
 M1 Net_76 net2041 net2042 net2043 PMOS W=48.251u L=4.595u
 M2 in2 in2 net2122 GND NMOS W=60.314u L=12.063u
 M3 Net_79 net2161 net2162 VDD PMOS W=24.413u L=6.606u
 M4 vref1 net2171 Net_79 net2173 NMOS W=24.413u L=6.031u
 M5 net2200 net2201 net2202 net2203 PMOS W=47.102u L=12.350u m=2
 M6 net2210 net2211 net2200 net2203 PMOS W=47.102u L=12.350u m=2
 M7 Net_63 Net_64 net2222 GND NMOS W=45.379u L=11.776u
 M8 net2230 Net_65 net2232 GND NMOS W=45.379u L=11.776u
 M9 Net_69 net2241 net2242 GND NMOS W=45.379u L=11.776u
 M10 net2250 net2251 net2252 GND NMOS W=45.379u L=11.776u
 M11 net2260 net2261 Net_66 GND NMOS W=45.379u L=11.776u
 M12 Net_69 Net_70 net2272 GND NMOS W=45.379u L=11.776u
 M13 net2280 Net_70 net2282 GND NMOS W=45.379u L=11.776u
 M14 Net_72 Net_71 net2292 GND NMOS W=45.379u L=11.776u
 M15 Net_73 net2301 net2302 GND NMOS W=45.379u L=11.776u
 M16 Net_73 net2311 net2312 GND NMOS W=45.379u L=11.776u
 M17 net2320 Net_73 net2322 GND NMOS W=45.379u L=11.776u
 M18 net2330 net2331 net2332 GND NMOS W=45.379u L=11.776u
 M19 net2340 net2341 net2342 VDD PMOS W=47.389u L=3.734u
 M20 net2350 net2351 net2352 VDD PMOS W=47.389u L=3.159u
 M21 Net_77 net2361 net2362 VDD PMOS W=47.676u L=3.159u
 M22 net2370 net2371 Net_80 VDD PMOS W=47.964u L=2.872u
 M23 Net_80 net2381 Net_68 VDD PMOS W=47.389u L=2.585u
 M24 net2390 Net_75 Net_74 VDD PMOS W=48.251u L=12.924u m=2
 M25 Net_74 Net_75 net2390 VDD PMOS W=48.251u L=12.924u m=2
 R1 net2410 net2411 47.5
 R2 net2420 net2421 2160
 R3 net2430 net2431 1500
.ENDS lmv341
