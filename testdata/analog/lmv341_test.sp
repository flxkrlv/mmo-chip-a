* SPICE netlist generated by mmo-chip analog export
* Source: lmv341
* Date: 2026-06-26
.GLOBAL VDD GND

.SUBCKT lmv341 Net_21 Net_37 Net_38 Net_39 Net_40 Net_41 Net_42 Net_43 Net_44 Net_45 Net_46 Net_47 Net_48 Net_49 Net_54 Net_58 Net_59 Net_60 Net_61 Net_62 Net_63 Net_64 Net_65 Net_66 Net_67 Net_68 Net_69 Net_70 Net_71 Net_72 Net_73 Net_74 Net_75 Net_76 Net_77 Net_78 Net_79 Net_80 VDD_1 in1 inp net2021 net2041 net2042 net2043 net2050 net2052 net2091 net2092 net2101 net2102 net2110 net2111 net2112 net2122 net2130 net2132 net2152 net2161 net2162 net2171 net2173 net2181 net2182 net2190 net2200 net2201 net2202 net2203 net2210 net2211 net2212 net2222 net2230 net2232 net2241 net2242 net2250 net2251 net2252 net2260 net2261 net2272 net2280 net2282 net2292 net2301 net2302 net2311 net2312 net2320 net2322 net2330 net2331 net2332 net2340 net2341 net2342 net2350 net2351 net2352 net2361 net2362 net2370 net2371 net2381 net2390 net2410 net2411 net2420 net2421 net2430 net2431 out1__2_ VDD GND

.PARAM Rp=25
.PARAM Rbase=200

* Minimal models for spice-ts compatibility
.MODEL PMOS PMOS (VTO=-0.7 KP=40u LAMBDA=0.02)
.MODEL NMOS NMOS (VTO=0.7 KP=120u LAMBDA=0.01)
.MODEL NPN_GEN NPN (BF=200 IS=1e-14 VAF=100)
.MODEL D_GEN D (IS=1e-14 BV=50)
.MODEL RES_GEN R

 M1 Net_54 in1 Net_21 VDD PMOS W=48.538u L=4.883u
 Q1 Net_67 Net_58 Net_67 NPN_GEN
 Q2 Net_62 net2021 Net_61 NPN_GEN
 D1 inp VDD_1 D_GEN
 M2 Net_76 net2041 net2042 net2043 PMOS W=48.251u L=4.595u
 M3 net2050 inp net2052 GND NMOS W=60.314u L=12.063u
 M4 Net_41 Net_40 Net_37 GND NMOS W=60.314u L=12.063u
 M5 Net_44 Net_43 Net_42 GND NMOS W=60.314u L=12.063u
 M6 Net_47 Net_46 Net_45 GND NMOS W=60.314u L=12.063u
 M7 out1__2_ net2091 net2092 GND NMOS W=60.314u L=12.063u
 M8 out1__2_ net2101 net2102 GND NMOS W=60.314u L=12.063u
 M9 net2110 net2111 net2112 GND NMOS W=60.314u L=12.063u
 M10 Net_78 Net_78 net2122 GND NMOS W=60.314u L=12.063u
 M11 net2130 VDD_1 net2132 GND NMOS W=60.026u L=1.723u
 M12 Net_38 Net_49 Net_39 GND NMOS W=60.026u L=1.723u
 M13 in1 Net_48 net2152 GND NMOS W=60.026u L=1.723u
 M14 Net_79 net2161 net2162 VDD PMOS W=24.413u L=6.606u
 M15 Net_54 net2171 Net_79 net2173 NMOS W=24.413u L=6.031u
 M16 Net_60 net2181 net2182 Net_60 PMOS W=47.102u L=12.350u m=2
 M17 net2190 Net_59 Net_60 Net_60 PMOS W=47.102u L=12.350u m=2
 M18 net2200 net2201 net2202 net2203 PMOS W=47.102u L=12.350u m=2
 M19 net2210 net2211 net2200 net2203 PMOS W=47.102u L=12.350u m=2
 M20 Net_63 Net_64 net2222 GND NMOS W=45.379u L=11.776u
 M21 net2230 Net_65 net2232 GND NMOS W=45.379u L=11.776u
 M22 Net_69 net2241 net2242 GND NMOS W=45.379u L=11.776u
 M23 net2250 net2251 net2252 GND NMOS W=45.379u L=11.776u
 M24 net2260 net2261 Net_66 GND NMOS W=45.379u L=11.776u
 M25 Net_69 Net_70 net2272 GND NMOS W=45.379u L=11.776u
 M26 net2280 Net_70 net2282 GND NMOS W=45.379u L=11.776u
 M27 Net_72 Net_71 net2292 GND NMOS W=45.379u L=11.776u
 M28 Net_73 net2301 net2302 GND NMOS W=45.379u L=11.776u
 M29 Net_73 net2311 net2312 GND NMOS W=45.379u L=11.776u
 M30 net2320 Net_73 net2322 GND NMOS W=45.379u L=11.776u
 M31 net2330 net2331 net2332 GND NMOS W=45.379u L=11.776u
 M32 net2340 net2341 net2342 VDD PMOS W=47.389u L=3.734u
 M33 net2350 net2351 net2352 VDD PMOS W=47.389u L=3.159u
 M34 Net_77 net2361 net2362 VDD PMOS W=47.676u L=3.159u
 M35 net2370 net2371 Net_80 VDD PMOS W=47.964u L=2.872u
 M36 Net_80 net2381 Net_68 VDD PMOS W=47.389u L=2.585u
 M37 net2390 Net_75 Net_74 VDD PMOS W=48.251u L=12.924u m=2
 M38 Net_74 Net_75 net2390 VDD PMOS W=48.251u L=12.924u m=2
 R1 net2410 net2411 RES_GEN r=1.9*Rp
 R2 net2420 net2421 RES_GEN r=10.8*Rbase
 R3 net2430 net2431 RES_GEN r=7.5*Rbase

.ENDS lmv341
